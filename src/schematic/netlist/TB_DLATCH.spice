** sch_path: /foss/designs/Chipaton2026/chipathon-2026-wwc/src/schematic/DLATCH/TB_DLATCH.sch
**.subckt TB_DLATCH
V1 d 0 0 PULSE('PAR_VDD' 0 PAR_DEL PAR_SLEW PAR_SLEW '0.5*PAR_PER' '1.0*PAR_PER')
Vsup dvdd 0 PAR_VDD
C1 q 0 'PAR_CLOAD'
V2 e 0 0 PULSE('PAR_VDD' 0 PAR_DEL PAR_SLEW PAR_SLEW '1.0*PAR_PER' '2.0*PAR_PER')
x1 d q e dvdd qn 0 DLATCH
C2 qn 0 'PAR_CLOAD'
**** begin user architecture code

.include /foss/pdks/gf180mcuD/libs.tech/ngspice/design.ngspice
.lib /foss/pdks/gf180mcuD/libs.tech/ngspice/sm141064.ngspice typical
.lib /foss/pdks/gf180mcuD/libs.tech/ngspice/smbb000149.ngspice typical

** PARAMETERS
.PARAM PAR_VDD=3.3
.PARAM PAR_CLOAD=10f
.PARAM PAR_SLEW=100p
.PARAM PAR_PER=10n
.PARAM PAR_DEL='0.1*PAR_PER'

** Rise/Fall 10-90%
.MEASURE TRAN tr1090 TRIG v(q) VAL='0.1*PAR_VDD' RISE=1 TARG v(q) VAL='0.9*PAR_VDD' RISE=1
.MEASURE TRAN tf9010 TRIG v(q) VAL='0.9*PAR_VDD' FALL=1 TARG v(q) VAL='0.1*PAR_VDD' FALL=1

** Delay Rise Fall
.MEASURE TRAN tdrise_a TRIG v(d) VAL='0.5*PAR_VDD' FALL=1 TARG v(q) VAL='0.5*PAR_VDD' RISE=1
.MEASURE TRAN tdfall_a TRIG v(d) VAL='0.5*PAR_VDD' RISE=1 TARG v(q) VAL='0.5*PAR_VDD' FALL=1

.MEASURE TRAN tdrise_b TRIG v(e) VAL='0.5*PAR_VDD' FALL=1 TARG v(q) VAL='0.5*PAR_VDD' RISE=1
.MEASURE TRAN tdfall_b TRIG v(e) VAL='0.5*PAR_VDD' RISE=1 TARG v(q) VAL='0.5*PAR_VDD' FALL=1

**Leakage current and average current
.MEASURE TRAN iavg AVG vsup#branch FROM=PAR_DEL TO='PAR_PER+PAR_DEL'
.MEASURE TRAN ileak AVG vsup#branch FROM='PAR_DEL+0.4*PAR_PER' TO='PAR_DEL+0.5*PAR_PER'

.control
save all
OP
TRAN 1p 21n
write TB_inv1.raw
plot v(d) v(e) v(q)
.endc

**** end user architecture code
**.ends

* expanding   symbol:  src/schematic/DLATCH/DLATCH.sym # of pins=6
** sym_path: /foss/designs/Chipaton2026/chipathon-2026-wwc/src/schematic/DLATCH/DLATCH.sym
** sch_path: /foss/designs/Chipaton2026/chipathon-2026-wwc/src/schematic/DLATCH/DLATCH.sch
.subckt DLATCH d q e DVDD qn DVSS
*.ipin d
*.ipin e
*.iopin DVDD
*.iopin DVSS
*.opin q
*.opin qn
x1 d e DVDD net2 DVSS NAND
x2 e net1 DVDD net3 DVSS NAND
x3 net2 qn DVDD q DVSS NAND
x4 q net3 DVDD qn DVSS NAND
x5 DVDD d net1 DVSS Inv1
.ends

* expanding   symbol:  src/schematic/NAND/NAND.sym # of pins=5
** sym_path: /foss/designs/Chipaton2026/chipathon-2026-wwc/src/schematic/NAND/NAND.sym
** sch_path: /foss/designs/Chipaton2026/chipathon-2026-wwc/src/schematic/NAND/NAND.sch
.subckt NAND a b DVDD vout DVSS
*.ipin a
*.opin vout
*.iopin DVDD
*.iopin DVSS
*.ipin b
XM3 vout a DVDD DVDD pfet_03v3 L=0.3u W=1.7u nf=1 ad='int((nf+1)/2) * W/nf * 0.18u' as='int((nf+2)/2) * W/nf * 0.18u' pd='2*int((nf+1)/2) * (W/nf + 0.18u)'
+ ps='2*int((nf+2)/2) * (W/nf + 0.18u)' nrd='0.18u / W' nrs='0.18u / W' sa=0 sb=0 sd=0
XM4 vout a net1 DVSS nfet_03v3 L=0.3u W=0.85u nf=1 ad='int((nf+1)/2) * W/nf * 0.18u' as='int((nf+2)/2) * W/nf * 0.18u' pd='2*int((nf+1)/2) * (W/nf + 0.18u)'
+ ps='2*int((nf+2)/2) * (W/nf + 0.18u)' nrd='0.18u / W' nrs='0.18u / W' sa=0 sb=0 sd=0
XM1 vout b DVDD DVDD pfet_03v3 L=0.3u W=1.7u nf=1 ad='int((nf+1)/2) * W/nf * 0.18u' as='int((nf+2)/2) * W/nf * 0.18u' pd='2*int((nf+1)/2) * (W/nf + 0.18u)'
+ ps='2*int((nf+2)/2) * (W/nf + 0.18u)' nrd='0.18u / W' nrs='0.18u / W' sa=0 sb=0 sd=0
XM2 net1 b DVSS DVSS nfet_03v3 L=0.3u W=0.85u nf=1 ad='int((nf+1)/2) * W/nf * 0.18u' as='int((nf+2)/2) * W/nf * 0.18u' pd='2*int((nf+1)/2) * (W/nf + 0.18u)'
+ ps='2*int((nf+2)/2) * (W/nf + 0.18u)' nrd='0.18u / W' nrs='0.18u / W' sa=0 sb=0 sd=0
.ends

* expanding   symbol:  src/schematic/INV/Inv1.sym # of pins=4
** sym_path: /foss/designs/Chipaton2026/chipathon-2026-wwc/src/schematic/INV/Inv1.sym
** sch_path: /foss/designs/Chipaton2026/chipathon-2026-wwc/src/schematic/INV/Inv1.sch
.subckt Inv1 DVDD vin vout DVSS
*.ipin vin
*.opin vout
*.iopin DVDD
*.iopin DVSS
XM3 vout vin DVDD DVDD pfet_03v3 L=0.3u W=1.7u nf=1 ad='int((nf+1)/2) * W/nf * 0.18u' as='int((nf+2)/2) * W/nf * 0.18u' pd='2*int((nf+1)/2) * (W/nf + 0.18u)'
+ ps='2*int((nf+2)/2) * (W/nf + 0.18u)' nrd='0.18u / W' nrs='0.18u / W' sa=0 sb=0 sd=0
XM4 vout vin DVSS DVSS nfet_03v3 L=0.3u W=0.85u nf=1 ad='int((nf+1)/2) * W/nf * 0.18u' as='int((nf+2)/2) * W/nf * 0.18u' pd='2*int((nf+1)/2) * (W/nf + 0.18u)'
+ ps='2*int((nf+2)/2) * (W/nf + 0.18u)' nrd='0.18u / W' nrs='0.18u / W' sa=0 sb=0 sd=0
.ends

.end
